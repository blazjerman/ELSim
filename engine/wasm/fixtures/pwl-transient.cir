ELSim ngspice WebAssembly PWL transient example
V1 in 0 PWL(0 0 2m 5 4m 2 6m 0)
R1 in out 1k
C1 out 0 10u
.tran 50u 12m
.print tran v(in) v(out)
.end
