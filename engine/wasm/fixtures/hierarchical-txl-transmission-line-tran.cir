Ground-return TXL transmission line with nested current probes
* Verify hierarchy-scoped current names for TXL port sense sources.
V1 source 0 PULSE(0 1 1n 50p 50p 10n 20n)
RSOURCE source input 50
XLINE input line_output LINEBLOCK
RLOAD line_output 0 50
.model TXL50 TXL(R=10 L=250n G=0 C=100p LENGTH=1)
.save v(line_output) i(v.xline.v__elsim_t1_p1) i(v.xline.v__elsim_t1_p2)
.subckt LINEBLOCK P1 P2
V__ELSIM_T1_P1 P1 __ELSIM_T1_P1 0
V__ELSIM_T1_P2 P2 __ELSIM_T1_P2 0
Y1 __ELSIM_T1_P1 0 __ELSIM_T1_P2 0 TXL50
.ends LINEBLOCK
.control
set filetype=ascii
tran 50p 12n
write /result.raw
quit
.endc
.end
