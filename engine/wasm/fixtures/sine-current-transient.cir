ELSim ngspice WebAssembly current-source SINE transient example
I1 0 out SIN(1m 2m 1k 0 0 0)
R1 out 0 1k
.tran 25u 250u
.print tran time V(out)
.end
