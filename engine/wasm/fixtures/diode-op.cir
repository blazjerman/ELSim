ELSim ngspice WebAssembly diode operating point
V1 in 0 5
R1 in out 1k
D1 out 0 DTEST
.model DTEST D(Is=1e-14 N=1)
.op
.print op v(out)
.end
