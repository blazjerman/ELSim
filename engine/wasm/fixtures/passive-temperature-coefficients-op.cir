* Verify native resistor instance temperature coefficients in the browser ngspice build.
V1 in 0 10
R1 in out 1k TC1=0.01
R2 out 0 1k
R3 in fixed_temp 1k TC1=0.01 TEMP=27
R4 fixed_temp 0 1k
.temp 127
.control
op
let tc1_divider = v(out)
let fixed_temp_divider = v(fixed_temp)
print tc1_divider fixed_temp_divider
.endc
.end
