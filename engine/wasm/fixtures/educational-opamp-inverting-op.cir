* Built-in educational op-amp configured as a 2x inverting amplifier.
* Generated by ELSim; edit the schematic to change this circuit.
VIN VIN 0 DC 0.5
VCC VPOS 0 DC 5
VEE 0 VNEG DC 5
XU1 0 FB VPOS VNEG VOUT ELSIM_EDUCATIONAL_OPAMP
RIN VIN FB 10k
RF VOUT FB 20k
RLOAD VOUT 0 10k
.subckt ELSIM_EDUCATIONAL_OPAMP INP INM VPOS VNEG OUT
RINP INP VNEG 1T
RINM INM VNEG 1T
EGAIN NDRIVE 0 INP INM 100000
ROUT NDRIVE OUT 50
DHI OUT VPOS ELSIM_EDUCATIONAL_OPAMP_D
DLO VNEG OUT ELSIM_EDUCATIONAL_OPAMP_D
.MODEL ELSIM_EDUCATIONAL_OPAMP_D D(Is=1e-14 N=1)
.ends ELSIM_EDUCATIONAL_OPAMP
.save @r.xu1.rout[i]
.op
.end
