* Electrically equivalent flattened reference for hierarchical-repeat-op
V1 vin1 0 DC 5
V2 vin2 0 DC 10
RLOAD1_1 vin1 mid1 500
RLOAD2_1 mid1 0 500
RLOAD1_2 vin2 mid2 500
RLOAD2_2 mid2 0 500
.save v(mid1) @RLOAD1_1[i] @RLOAD2_1[i]
.save v(mid2) @RLOAD1_2[i] @RLOAD2_2[i]
.op
.print op v(vin1) v(mid1) v(vin2) v(mid2)
.control
set filetype=ascii
op
write /result.raw all
.endc
.end
