ELSim finite pulse count regression for voltage and current sources
V1 vin 0 PULSE(0 5 0 1u 1u 2m 4m 2)
R1 vin 0 1k
I1 0 iout PULSE(0 1m 0 1u 1u 2m 4m 2)
R2 iout 0 1k
.tran 20u 12m
.print tran time V(vin) V(iout)
.end
