ngspice model name punctuation probe
V1 in 0 1
R1 in out 1k
D1 out 0 D!TEST
D2 out 0 D#TEST
D3 out 0 D$TEST
D4 out 0 D%TEST
D5 out 0 D[1]
D6 out 0 D[!#$%]
D7 out 0 D]TEST
D8 out 0 D[TEST
D9 out 0 D[]
.model D!TEST D (IS=1e-14 N=1)
.model D#TEST D (IS=1e-14 N=1)
.model D$TEST D (IS=1e-14 N=1)
.model D%TEST D (IS=1e-14 N=1)
.model D[1] D (IS=1e-14 N=1)
.model D[!#$%] D (IS=1e-14 N=1)
.model D]TEST D (IS=1e-14 N=1)
.model D[TEST D (IS=1e-14 N=1)
.model D[] D (IS=1e-14 N=1)
.control
op
print v(out)
quit
.endc
.end
