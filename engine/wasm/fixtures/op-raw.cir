ELSim DC operating-point raw output
V1 in 0 DC 5
R1 in out 1k
R2 out 0 1k
.op
.save all @r1[i] @r2[i] @v1[i]
.control
set filetype=ascii
run
write /result.raw all
quit
.endc
.end
