ELSim ngspice WebAssembly RC transient
V1 in 0 PULSE(0 5 0 1u 1u 5m 10m)
R1 in out 1k
C1 out 0 10u
.tran 100u 10m
.print tran v(out)
.end
