ELSim independent current-source PWL transient
I1 0 out PWL(0 0 1m 1m 2m 0 3m -1m 4m 0)
R1 out 0 1k
.tran 20u 4m
.save all @i1[current]
.control
set filetype=ascii
run
write /result.raw all
quit
.endc
.end
