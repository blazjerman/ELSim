ELSim transient measurement time window regression
V1 out 0 PWL(0 0 1m 2 2m 0 3m 4 4m 0 5m 2 6m 0)
R1 out 0 1k
.tran 100u 6m
.control
set filetype=ascii
run
meas tran ELSIM_window_max_0 MAX v(out) FROM=2m TO=4m
meas tran ELSIM_window_min_0 MIN v(out) FROM=2m TO=4m
meas tran ELSIM_window_avg_0 AVG v(out) FROM=2m TO=4m
meas tran ELSIM_window_rms_0 RMS v(out) FROM=2m TO=4m
write /result.raw all
quit
.endc
.end
