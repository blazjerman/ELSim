Ngspice .LIB section-name compatibility: FAST$LOW
V1 IN 0 10
R1 IN OUT 1k
.LIB lib-section-dollar-op.lib FAST$LOW
X1 OUT 0 TEST
.op
.print op v(out)
.end
