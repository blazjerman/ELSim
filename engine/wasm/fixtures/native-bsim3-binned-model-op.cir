ELSim native ngspice BSIM3 model-binning check
VDS d 0 1
VGS g 0 1.2
M1 d g 0 0 NCH L=1u W=10u
.MODEL NCH.1 NMOS LEVEL=8 VERSION=3.3.0 LMIN=0.5u LMAX=2u WMIN=0.5u WMAX=20u VTH0=0.7 U0=500
.MODEL NCH.2 NMOS LEVEL=8 VERSION=3.3.0 LMIN=2u LMAX=10u WMIN=0.5u WMAX=20u VTH0=1.5 U0=500
.op
.print op v(d) v(g)
.end
