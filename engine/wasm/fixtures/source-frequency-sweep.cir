* Source frequency stepping regression
.param ELSIM_SWEEP_FREQ_V1_SINE_FREQUENCY=1k
.param ELSIM_SWEEP_FREQ_V2_SFFM_CARRIERFREQUENCY=1k
.param ELSIM_SWEEP_FREQ_V3_SFFM_SIGNALFREQUENCY=100
V1 sine 0 SIN(0 1 {ELSIM_SWEEP_FREQ_V1_SINE_FREQUENCY} 0 0 0)
R1 sine 0 1k
V2 carrier 0 SFFM(0 0.5 {ELSIM_SWEEP_FREQ_V2_SFFM_CARRIERFREQUENCY} 0 100)
R2 carrier 0 1k
V3 modulation 0 SFFM(0 1 1k 1 {ELSIM_SWEEP_FREQ_V3_SFFM_SIGNALFREQUENCY})
R3 modulation 0 1k
.tran 10u 2m
.control
set filetype=ascii
alterparam ELSIM_SWEEP_FREQ_V1_SINE_FREQUENCY=1k
alterparam ELSIM_SWEEP_FREQ_V2_SFFM_CARRIERFREQUENCY=1k
alterparam ELSIM_SWEEP_FREQ_V3_SFFM_SIGNALFREQUENCY=100
reset
run
write /result-0.raw all
alterparam ELSIM_SWEEP_FREQ_V1_SINE_FREQUENCY=2k
alterparam ELSIM_SWEEP_FREQ_V2_SFFM_CARRIERFREQUENCY=2k
alterparam ELSIM_SWEEP_FREQ_V3_SFFM_SIGNALFREQUENCY=200
reset
run
write /result-1.raw all
quit
.endc
.end
