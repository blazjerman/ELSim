ELSim ngspice WebAssembly RLC AC sweep
V1 in 0 AC 1
R1 in n1 100
L1 n1 out 10m
C1 out 0 100n
.ac dec 10 1k 10k
.print ac vm(out)
.end
