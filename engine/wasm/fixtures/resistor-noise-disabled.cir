ELSim resistor noise disabled
V1 in 0 AC 1
R1 in out 1k NOISY=0
R2 out 0 1k NOISY=0
.control
noise v(out) v1 dec 10 1 1k
setplot noise1
print onoise_spectrum
.endc
.end
