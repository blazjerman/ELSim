* LTspice table() and if() translated to ngspice-compatible expressions
Vin in 0 DC 0
Btable out-table 0 V={((V(in) < 0) ? 0 : ((V(in) > 2) ? 10 : pwl(V(in), 0, 0, 1, 5, 2, 10)))}
Rtable out-table 0 1k
Bif out-if 0 V={(((V(in) - 0.5) > 1e-12) ? 5 : 0)}
Rif out-if 0 1k
Bfunction out-function 0 V={(((V(in) + 1) * 2) + 3)}
Rfunction out-function 0 1k
.control
set filetype=ascii
dc Vin -1 3 0.4
write /result.raw all
quit
.endc
.end
