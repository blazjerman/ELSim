ELSim ngspice WebAssembly AC raw output
V1 in 0 DC 0 AC 1 0
R1 in out 1k
C1 out 1u
.control
set filetype=ascii
ac dec 4 10 10k
write /result.raw all
quit
.endc
.end
