ELSim educational user op amp import and solve
VCC VP 0 5
VIN IN 0 1
XU1 IN OUT VP 0 OUT ELSIM_EDU_OPAMP
RLOAD OUT 0 10k
.SUBCKT ELSIM_EDU_OPAMP INP INM VPOS VNEG OUT
EGAIN NDRIVE 0 INP INM 100000
ROUT NDRIVE OUT 50
DHI OUT VPOS DCLAMP
DLO VNEG OUT DCLAMP
.MODEL DCLAMP D(Is=1e-14 N=1)
.ENDS ELSIM_EDU_OPAMP
.op
.print op v(out) i(rload)
.end
