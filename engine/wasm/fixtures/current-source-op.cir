ELSim ngspice WebAssembly independent current source
I1 0 out 1m
R1 out 0 1k
.op
.print op v(out)
.save all @i1[current]
.control
set filetype=ascii
run
write /result.raw all
quit
.endc
.end
