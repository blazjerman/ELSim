* ELSim built-in nested reusable divider walkthrough example
V1 IN5 0 5
V2 IN10 0 10
X1 IN5 OUT5 0 ELSIM_SHEET_sheet_divider PARAMS: RINPUT=1k
X2 IN10 OUT10 0 ELSIM_SHEET_sheet_divider PARAMS: RINPUT=2k
.SUBCKT ELSIM_SHEET_sheet_core A B PARAMS: RCORE=1k
RCORE A B {RCORE}
.ENDS ELSIM_SHEET_sheet_core
.SUBCKT ELSIM_SHEET_sheet_divider IN OUT GND PARAMS: RINPUT=1k
RMAIN IN OUT {RINPUT}
XCORE OUT GND ELSIM_SHEET_sheet_core
.ENDS ELSIM_SHEET_sheet_divider
.save v(OUT5) v(OUT10) @r.x2.xcore.rcore[i]
.op
.print op v(OUT5) v(OUT10)
.control
set filetype=ascii
op
write /result.raw all
.endc
.end
