ELSim ngspice punctuation-rich subcircuit pin names
V1 in_bang 0 5
V2 in_colon 0 2.5
X1 in_bang in_colon out PUNCTUATED
R1 out 0 1k
.SUBCKT PUNCTUATED IN! IN:1 OUT#1
E1 OUT#1 0 IN! IN:1 2
.ENDS PUNCTUATED
V3 in3 0 5
X3 in3 out3 BRACKET_PIN
R3 out3 0 1k
V4 in4 0 5
X4 in4 out4 PERCENT_PIN
R4 out4 0 1k
V5 in5 0 5
X5 in5 out5 ANGLE_PIN
R5 out5 0 1k
V6 in6 0 5
X6 in6 out6 TILDE_PIN
R6 out6 0 1k
V7 in7 0 5
X7 in7 out7 BACKSLASH_PIN
R7 out7 0 1k
V8 in8 0 5
X8 in8 out8 BACKTICK_PIN
R8 out8 0 1k
V9 in9 0 5
X9 in9 out9 CLOSE_BRACKET_PIN
R9 out9 0 1k
.SUBCKT BRACKET_PIN IN[1] OUT
RIN3 IN[1] OUT 1k
.ENDS BRACKET_PIN
.SUBCKT PERCENT_PIN IN%2 OUT
RIN4 IN%2 OUT 1k
.ENDS PERCENT_PIN
.SUBCKT ANGLE_PIN IN<3> OUT
RIN5 IN<3> OUT 1k
.ENDS ANGLE_PIN
.SUBCKT TILDE_PIN IN~4 OUT
RIN6 IN~4 OUT 1k
.ENDS TILDE_PIN
.SUBCKT BACKSLASH_PIN IN\5 OUT
RIN7 IN\5 OUT 1k
.ENDS BACKSLASH_PIN
.SUBCKT BACKTICK_PIN IN`6 OUT
RIN8 IN`6 OUT 1k
.ENDS BACKTICK_PIN
.SUBCKT CLOSE_BRACKET_PIN IN]7 OUT
RIN9 IN]7 OUT 1k
.ENDS CLOSE_BRACKET_PIN
.op
.print op v(out) v(out3) v(out4) v(out5) v(out6) v(out7) v(out8) v(out9)
.end
