Four-terminal NPN BJT substrate terminal runs through the native ngspice Q device
VCE c 0 5
VBE b 0 0.7
VSUB sub 0 0.1
Q1 c b 0 sub QMOD
.model QMOD NPN (IS=1e-14 BF=100 BR=1)
.op
.print op i(VCE) i(VSUB)
.end
