Imported subcircuit with a long arithmetic default
V1 IN 0 1
X1 IN OUT AMP_LONG
R1 OUT 0 1k
.SUBCKT AMP_LONG IN OUT PARAMS: GAIN={1+1+1+1+1+1+1+1+1+1+1+1+1+1+1+1+1+1+1+1+1+1+1+1+1+1+1+1+1+1+1+1+1+1+1+1+1+1+1+1+1+1+1+1+1+1+1+1+1+1+1+1+1+1+1+1+1+1+1+1+1+1+1+1+1+1+1+1+1+1+1+1+1+1+1+1+1+1+1+1+1+1+1+1+1+1+1+1+1+1+1+1+1+1+1+1+1+1+1+1+1+1+1+1+1+1+1+1+1+1+1+1+1+1+1+1+1+1+1+1+1+1+1+1+1+1+1+1}
E1 OUT 0 IN 0 {GAIN}
.ENDS AMP_LONG
.op
.print op v(out)
.end
