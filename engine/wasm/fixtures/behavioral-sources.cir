ELSim bounded behavioral source regression
V1 in 0 3
B1 out-v 0 V={V(in)*2}
R1 out-v 0 1k
B2 out-i 0 I={V(in)/1k}
R2 out-i 0 1k
.save all @B1[i] @B2[i]
.op
.control
set filetype=ascii
run
write /result.raw all
quit
.endc
.end
