ELSim transient initial condition regression
V1 in 0 0
R1 in out 1k
C1 out 0 10u
.ic v(out)=2
.tran 10u 30m uic
.control
set filetype=ascii
run
write /result.raw all
quit
.endc
.end
