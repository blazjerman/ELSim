* Small-signal transfer function and impedances of a 1:1 divider
V1 in 0 DC 0
R1 in out 1k
R2 out 0 1k
.tf V(out) V1
.control
set filetype=ascii
tf v(out) V1
write /result.raw all
quit
.endc
.end
