ELSim imported subcircuit log10 parameter operating point
V1 IN 0 1
XLOG IN OUT LOG_GAIN
XOVERRIDE IN OUT_OVERRIDE LOG_GAIN GAIN={log10(1000)}
.SUBCKT LOG_GAIN IN OUT GAIN={log10(100)}
E1 OUT 0 IN 0 {GAIN}
.ENDS LOG_GAIN
.op
.print op v(out) v(out_override)
.end
