ELSim built-in educational five-pin op amp
VIN VIN 0 1
VCC VPOS 0 5
VEE VNEG 0 -5
XU1 VIN FB VPOS VNEG VOUT ELSIM_EDUCATIONAL_OPAMP
R1 FB 0 1k
R2 VOUT FB 1k
RLOAD VOUT 0 10k
.SUBCKT ELSIM_EDUCATIONAL_OPAMP INP INM VPOS VNEG OUT
RINP INP VNEG 1T
RINM INM VNEG 1T
EGAIN NDRIVE 0 INP INM 100000
ROUT NDRIVE OUT 50
DHI OUT VPOS ELSIM_EDUCATIONAL_OPAMP_D
DLO VNEG OUT ELSIM_EDUCATIONAL_OPAMP_D
.MODEL ELSIM_EDUCATIONAL_OPAMP_D D(Is=1e-14 N=1)
.ENDS ELSIM_EDUCATIONAL_OPAMP
.save all @r.xu1.rout[i]
.op
.end
