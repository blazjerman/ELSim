ELSim built-in educational five-pin op amp
VIN VIN 0 1
VCC VPOS 0 5
VEE VNEG 0 -5
XU1 VIN FB VPOS VNEG VOUT ELSIM_EDUCATIONAL_OPAMP
R1 FB 0 1k
R2 VOUT FB 1k
RLOAD VOUT 0 10k
.SUBCKT ELSIM_EDUCATIONAL_OPAMP INP INM VPOS VNEG OUT
RINP INP VNEG 1T
RINM INM VNEG 1T
BGAIN NDRIVE 0 V={max(min(1e6*(V(INP)-V(INM)),V(VPOS)),V(VNEG))}
ROUT NDRIVE OUT 50
.ENDS ELSIM_EDUCATIONAL_OPAMP
.save all @r.xu1.rout[i]
.op
.end
