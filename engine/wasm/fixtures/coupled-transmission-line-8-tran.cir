8-conductor coupled-line transient using an imported subcircuit wrapper
* This deck exercises all eight native ngspice P/CPL conductors and a 36-entry RLGC triangle.
V1 source 0 PULSE(0 1 1n 50p 50p 8n 20n)
RSOURCE source line_in1 50
XLINE line_in1 0 0 0 0 0 0 0 0 line_out1 line_out2 line_out3 line_out4 line_out5 line_out6 line_out7 line_out8 0 COUPLED_LINE
RLOAD1 line_out1 0 50
RLOAD2 line_out2 0 50
RLOAD3 line_out3 0 50
RLOAD4 line_out4 0 50
RLOAD5 line_out5 0 50
RLOAD6 line_out6 0 50
RLOAD7 line_out7 0 50
RLOAD8 line_out8 0 50
.MODEL CPL8 CPL LENGTH=1
+ R=1 0 0 0 0 0 0 0 1
+ 0 0 0 0 0 0 1 0 0
+ 0 0 0 1 0 0 0 0 1
+ 0 0 0 1 0 0 1 0 1
+ L=3.83572e-07 6e-08 3e-08 2e-08 1.5e-08 1.2e-08 1e-08 8.57142857e-09 3.83572e-07
+ 6e-08 3e-08 2e-08 1.5e-08 1.2e-08 1e-08 3.83572e-07 6e-08 3e-08
+ 2e-08 1.5e-08 1.2e-08 3.83572e-07 6e-08 3e-08 2e-08 1.5e-08 3.83572e-07
+ 6e-08 3e-08 2e-08 3.83572e-07 6e-08 3e-08 3.83572e-07 6e-08 3.83572e-07
+ G=0 0 0 0 0 0 0 0 0
+ 0 0 0 0 0 0 0 0 0
+ 0 0 0 0 0 0 0 0 0
+ 0 0 0 0 0 0 0 0 0
+ C=9.143579e-11 -8e-12 -4e-12 -2.66666667e-12 -2e-12 -1.6e-12 -1.33333333e-12 -1.14285714e-12 9.143579e-11
+ -8e-12 -4e-12 -2.66666667e-12 -2e-12 -1.6e-12 -1.33333333e-12 9.143579e-11 -8e-12 -4e-12
+ -2.66666667e-12 -2e-12 -1.6e-12 9.143579e-11 -8e-12 -4e-12 -2.66666667e-12 -2e-12 9.143579e-11
+ -8e-12 -4e-12 -2.66666667e-12 9.143579e-11 -8e-12 -4e-12 9.143579e-11 -8e-12 9.143579e-11
.SUBCKT COUPLED_LINE IN1 IN2 IN3 IN4 IN5 IN6 IN7 IN8 GND1 OUT1 OUT2 OUT3 OUT4 OUT5 OUT6 OUT7 OUT8 GND2
P1 IN1 IN2 IN3 IN4 IN5 IN6 IN7 IN8 GND1 OUT1 OUT2 OUT3 OUT4 OUT5 OUT6 OUT7 OUT8 GND2 CPL8 LEN=1
.ENDS COUPLED_LINE
.save v(line_in1) v(line_in2) v(line_in3) v(line_in4) v(line_in5) v(line_in6) v(line_in7) v(line_in8) v(line_out1) v(line_out2) v(line_out3) v(line_out4) v(line_out5) v(line_out6) v(line_out7) v(line_out8)
.control
set filetype=ascii
tran 50p 12n
write /result.raw
quit
.endc
.end
