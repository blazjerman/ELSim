ELSim ngspice VCCS multiplier
VCTRL ctrl 0 1
G1 0 out ctrl 0 1m M=3
R1 out 0 1k
.op
.print op v(out)
.end
